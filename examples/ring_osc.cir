5-stage CMOS ring oscillator
.model nch nmos level=1 vto=0.5 kp=300u lambda=0.05 cgso=3e-10 cgdo=3e-10
.model pch pmos level=1 vto=-0.5 kp=100u lambda=0.05 cgso=3e-10 cgdo=3e-10
Vdd vdd 0 1.8
* start-up kick: 100 uA for 50 ps into n1 (DC solution is an unstable midpoint)
Ikick 0 n1 PULSE(0 100u 0.1n 10p 10p 50p 100n)
Mn1 n2 n1 0 0 nch W=1u L=0.18u
Mp1 n2 n1 vdd vdd pch W=3u L=0.18u
Mn2 n3 n2 0 0 nch W=1u L=0.18u
Mp2 n3 n2 vdd vdd pch W=3u L=0.18u
Mn3 n4 n3 0 0 nch W=1u L=0.18u
Mp3 n4 n3 vdd vdd pch W=3u L=0.18u
Mn4 n5 n4 0 0 nch W=1u L=0.18u
Mp4 n5 n4 vdd vdd pch W=3u L=0.18u
Mn5 n1 n5 0 0 nch W=1u L=0.18u
Mp5 n1 n5 vdd vdd pch W=3u L=0.18u
* wiring/fan-out load per stage
C1 n1 0 5f
C2 n2 0 5f
C3 n3 0 5f
C4 n4 0 5f
C5 n5 0 5f
.tran 2p 6n
.end
